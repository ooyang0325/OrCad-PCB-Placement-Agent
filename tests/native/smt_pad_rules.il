; Pure opt-in SMT geometry validation; no board, library, placement or Save calls.
procedure(opaManagedSmtPadRulesAcceptance()
    let((count box rejected before after)
        count = 0
        box = '((0 0) (20000 10000))
        foreach(kind '("none" "circle_drill")
            opaRequire(opaManagedSmtHoleFree(kind 0.0 0.0 0.0)
                "Zero-drill SMT template was incorrectly rejected.")
            count = count + 1)
        foreach(data '(("circle_drill" 0.7 0.0 0.0)
                       ("oval slot" 0.0 0.6 1.4)
                       ("rectangle slot" 0.0 0.6 1.4)
                       ("none" 0.0 0.1 0.0)
                       ("none" 0.0 0.0 0.1)
                       ("none" nil 0.0 0.0)
                       ("unknown" 0.0 0.0 0.0))
            opaRequire(!opaManagedSmtHoleFree(car(data) cadr(data) nth(2 data) nth(3 data))
                "A drilled, slotted or incomplete template was accepted as hole-free.")
            count = count + 1)
        foreach(kind '("RECTANGLE" "SQUARE" "CIRCLE" "OBLONG_X" "OBLONG_Y")
            opaManagedPadStyle(kind 0.0 nil 0.0 0 box)
            count = count + 1)
        foreach(kind '("RECTANGLE" "ROUNDED_RECTANGLE" "CHAMFERED_RECTANGLE")
            foreach(corners '(nil "UR" "UR-LR" "UR-LR-LL-UL")
                opaManagedPadStyle(kind 0.25 corners 0.0 0 box)
                count = count + 1))
        foreach(data '(("RECTANGLE" 0.6 nil 0.0 0)
                       ("ROUNDED_RECTANGLE" -0.1 nil 0.0 0)
                       ("RECTANGLE" 0.1 "UR-UR" 0.0 0)
                       ("RECTANGLE" 0.1 "UR-" 0.0 0)
                       ("RECTANGLE" 0.1 "UNKNOWN" 0.0 0)
                       ("CIRCLE" 0.1 nil 0.0 0)
                       ("OBLONG_X" 0.0 "UR" 0.0 0)
                       ("RECTANGLE" 0.0 nil 0.1 0)
                       ("RECTANGLE" 0.0 nil 0.0 8)
                       ("SHAPE" 0.0 nil 0.0 0)
                       ("FLASH" 0.0 nil 0.0 0)
                       ("DONUT" 0.0 nil 0.0 0))
            rejected = errset(opaManagedPadStyle(car(data) cadr(data) nth(2 data)
                nth(3 data) nth(4 data) box) nil)
            opaRequire(!rejected "Unsupported native SMT pad style was accepted.")
            count = count + 1)
        before = opaStable(list("ROUNDED_RECTANGLE" 0.25000001 "UR"))
        after = opaStable(list("ROUNDED_RECTANGLE" 0.25000002 "UR"))
        opaRequire(before != after "Corner metadata precision was lost.")
        count = count + 1
        count
    )
)
